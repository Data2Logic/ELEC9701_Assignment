ADE simulation setup
Test 9701:Differential_Comparator:1: 9701/Differential_Comparator/schematic, simulator spectre
  Models: /usr/local/cadence/FreePDK45/ncsu_basekit/models/hspice/hspice_stat.include
  Variables: V1n = 0.45; V1p = .3; V2n = 0.6; V2p = 0.6; F = 0; T = 100n
  Temperature: 27
  Analysis tran: stop=500n
  Signals: /V1-, /V1+, /V2-, /V2+, /Vout1 as Vout1, /Vout2 as Vout2, /out as OUT, /net10 as Not OUT, /net9 as CLK
Run mode: Single Run, Sweeps and Corners
