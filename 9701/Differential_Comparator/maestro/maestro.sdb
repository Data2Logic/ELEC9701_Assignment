ADE simulation setup
Run mode: Single Run, Sweeps and Corners
Tests:
  9701:Differential_Comparator:1: 9701/Differential_Comparator/schematic, simulator spectre
    Variables: F = 0; T = 100n; V1n = 0.45; V1p = .3; V2n = 0.6; V2p = 0.6
