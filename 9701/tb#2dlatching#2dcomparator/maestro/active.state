ADE simulation setup
Test 9701:tb-latching-comparator:1: 9701/tb-latching-comparator/schematic, simulator spectre
  Models: /usr/local/cadence/FreePDK45/ncsu_basekit/models/hspice/hspice_stat.include
  Temperature: 27
  Analysis tran: stop=10u
  Signals: /V+, /V-, /clo, /O
Run mode: Single Run, Sweeps and Corners
