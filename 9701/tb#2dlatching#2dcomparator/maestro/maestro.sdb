ADE simulation setup
Run mode: Single Run, Sweeps and Corners
Tests:
  9701:tb-latching-comparator:1: 9701/tb-latching-comparator/schematic, simulator spectre
