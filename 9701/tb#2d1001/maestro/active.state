ADE simulation setup
Test 9701:tb-1001:1: 9701/tb-1001/schematic, simulator spectre
  Models: /usr/local/cadence/FreePDK45/ncsu_basekit/models/hspice/hspice_stat.include
  Temperature: 27
  Analysis tran: stop=4u
  Signals: /net010, /net06, /net015
Run mode: Single Run, Sweeps and Corners
