ADE simulation setup
Run mode: Single Run, Sweeps and Corners
Tests:
  9701:tb-1001:1: 9701/tb-1001/schematic, simulator spectre
