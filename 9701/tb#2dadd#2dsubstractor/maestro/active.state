ADE simulation setup
Test 9701:tb-add-substractor:1: 9701/tb-add-substractor/schematic, simulator spectre
  Models: /usr/local/cadence/FreePDK45/ncsu_basekit/models/hspice/hspice_stat.include
  Temperature: 27
  Analysis tran: stop=2u
  Signals: /vP, /vN, /O
Run mode: Single Run, Sweeps and Corners
