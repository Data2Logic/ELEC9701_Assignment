ADE simulation setup
Run mode: Single Run, Sweeps and Corners
Tests:
  9701:tb-add-substractor:1: 9701/tb-add-substractor/schematic, simulator spectre
