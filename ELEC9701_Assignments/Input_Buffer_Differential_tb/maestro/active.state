ADE simulation setup
Test ELEC9701_Assignments:Input_Buffer_Differential_tb:1: ELEC9701_Assignments/Input_Buffer_Differential_tb/schematic, simulator spectre
  Models: /usr/local/cadence/FreePDK45/ncsu_basekit/models/hspice/hspice_stat.include
  Variables: K = 3; L = 50n; W = 134n
  Temperature: 27
  Analysis tran: stop=1u
  Signals: /V+, /V-, /Out+, /Out-
Run mode: Single Run, Sweeps and Corners
