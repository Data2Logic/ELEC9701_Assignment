ADE simulation setup
Run mode: Single Run, Sweeps and Corners
Tests:
  ELEC9701_Assignments:Input_Buffer_Differential_tb:1: ELEC9701_Assignments/Input_Buffer_Differential_tb/schematic, simulator spectre
    Variables: K = 3; L = 50n; W = 134n
