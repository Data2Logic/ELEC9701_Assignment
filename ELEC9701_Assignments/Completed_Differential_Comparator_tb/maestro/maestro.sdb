ADE simulation setup
Run mode: Single Run, Sweeps and Corners
Tests:
  ELEC9701_Assignments:Completed_Differential_Comparator_tb:1: ELEC9701_Assignments/Completed_Differential_Comparator_tb/schematic, simulator spectre
    Variables: L = 50n; R = 10k; W = 134n; X = 900m; Y = 100m
