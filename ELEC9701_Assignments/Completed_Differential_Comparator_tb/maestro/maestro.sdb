ADE simulation setup
Run mode: Single Run, Sweeps and Corners
Tests:
  ELEC9701_Assignments:Completed_Differential_Comparator_tb:1: ELEC9701_Assignments/Completed_Differential_Comparator_tb/schematic, simulator spectre
    Variables: R = 10k; V1n = 0.8; V1p = 0.9; V2n = 0.4; V2p = 0.9; Vref = 0.45; T = 5n; W = 90n; T_signal_1n = 10n; T_signal_1p = 0; T_signal_2n = 0; T_signal_2p = 0; Delay = 7.5386n
