ADE simulation setup
Run mode: Single Run, Sweeps and Corners
Tests:
  ELEC9701_Assignments:Completed_Differential_Comparator_tb:1: ELEC9701_Assignments/Completed_Differential_Comparator_tb/schematic, simulator spectre
    Variables: R = 10k; V1n = 0.2; V1p = 0.4; V2n = 0.2; V2p = 0.6; Vref = 0.45; T = 1n
