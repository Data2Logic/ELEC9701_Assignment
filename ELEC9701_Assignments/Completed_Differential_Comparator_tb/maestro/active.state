ADE simulation setup
Test ELEC9701_Assignments:Completed_Differential_Comparator_tb:1: ELEC9701_Assignments/Completed_Differential_Comparator_tb/schematic, simulator spectre
  Models: /usr/local/cadence/FreePDK45/ncsu_basekit/models/hspice/hspice_stat.include
  Variables: L = 50n; R = 10k; W = 134n; X = 900m; Y = 100m
  Temperature: 27
  Analysis tran: stop=2u
  Signals: /OUT+, /LATCH, /I1+, /I1-, /I2+, /I2-, /I12/net011, /I12/net012
Run mode: Single Run, Sweeps and Corners
Setup values for test ELEC9701_Assignments:Completed_Differential_Comparator_tb:1: V1n = 0.2; V1p = 0.8; V2n = 0.1; V2p = 0.2
