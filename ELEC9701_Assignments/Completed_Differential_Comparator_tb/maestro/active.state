ADE simulation setup
Test ELEC9701_Assignments:Completed_Differential_Comparator_tb:1: ELEC9701_Assignments/Completed_Differential_Comparator_tb/schematic, simulator spectre
  Models: /usr/local/cadence/FreePDK45/ncsu_basekit/models/hspice/hspice_stat.include
  Variables: Delay = 7.5386n; R = 10k; V1n = 0.8; V1p = 0.9; V2n = 0.4; V2p = 0.9; Vref = 0.45; T = 5n; W = 90n; T_signal_1n = 10n; T_signal_1p = 0; T_signal_2n = 0; T_signal_2p = 0
  Temperature: 27
  Analysis tran: stop=50n
  Signals: /V1+, /V1-, /V2+, /V2-, /CLK, /Vout
Run mode: Single Run, Sweeps and Corners
Setup values for test ELEC9701_Assignments:Completed_Differential_Comparator_tb:1: V1n = 0.2; V1p = 0.8; V2n = 0.1; V2p = 0.2
