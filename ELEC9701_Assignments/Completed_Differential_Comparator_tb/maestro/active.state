ADE simulation setup
Test ELEC9701_Assignments:Completed_Differential_Comparator_tb:1: ELEC9701_Assignments/Completed_Differential_Comparator_tb/schematic, simulator spectre
  Models: /usr/local/cadence/FreePDK45/ncsu_basekit/models/hspice/hspice_stat.include
  Variables: R = 10k; V1n = 0.2; V1p = 0.8; V2n = 0.1; V2p = 0.2
  Temperature: 27
  Analysis tran: stop=1u
  Signals: /V1+, /V1-, /V2+, /V2-, /Vout
Run mode: Single Run, Sweeps and Corners
