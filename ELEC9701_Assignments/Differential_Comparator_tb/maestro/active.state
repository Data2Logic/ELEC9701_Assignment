ADE simulation setup
Test ELEC9701_Assignments:Differential_Comparator_tb:1: ELEC9701_Assignments/Differential_Comparator_tb/schematic, simulator spectre
  Models: /usr/local/cadence/FreePDK45/ncsu_basekit/models/hspice/hspice_stat.include
  Variables: L = 50n; R = 10k; W = 135n; X = 100m; Y = 200m
  Temperature: 27
  Analysis tran: stop=2u
  Signals: /I1+, /I1-, /LATCH, /I2+, /I2-, /OUT+, /OUT-
Run mode: Single Run, Sweeps and Corners
