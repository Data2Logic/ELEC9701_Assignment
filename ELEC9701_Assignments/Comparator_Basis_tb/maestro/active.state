ADE simulation setup
Test ELEC9701_Assignments:Comparator_Basis_tb:1: ELEC9701_Assignments/Comparator_Basis_tb/schematic, simulator spectre
  Temperature: 27
Run mode: Single Run, Sweeps and Corners
