ADE simulation setup
Run mode: Single Run, Sweeps and Corners
Tests:
  ELEC9701_Assignments:Inveter_tb:1: ELEC9701_Assignments/Inveter_tb/schematic, simulator spectre
