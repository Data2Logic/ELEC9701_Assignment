ADE simulation setup
Test ELEC9701_Assignments:Inveter_tb:1: ELEC9701_Assignments/Inveter_tb/schematic, simulator spectre
  Models: /usr/local/cadence/FreePDK45/ncsu_basekit/models/hspice/hspice_stat.include
  Temperature: 27
  Analysis tran: stop=500n
  Signals: /In, /Out, /I0/VDD (terminal)
Run mode: Single Run, Sweeps and Corners
